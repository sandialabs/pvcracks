* One-diode solar module simulation

* Define the diode model
.model sd1 D (IS=2.993072180920015e-10 N=0.9579244607561158 EG=1.12 BV=12.0)
.model sdby D (IS=1e-7 N=1 BV=100.0 IBV=20)

* Define the DC sweep
V1 1 0

*elementary diode model
Rs0 1 2 0.005117383333333334
Rp0 2 3 5.118051725103711
D0 2 3 sd1
I0 3 2 10.361114098081137

*elementary diode model
Rs1 3 4 0.005117383333333334
Rp1 4 5 5.118051725103711
D1 4 5 sd1
I1 5 4 10.361114098081137

*elementary diode model
Rs2 5 6 0.005117383333333334
Rp2 6 7 5.118051725103711
D2 6 7 sd1
I2 7 6 10.361114098081137

*elementary diode model
Rs3 7 8 0.005117383333333334
Rp3 8 9 5.118051725103711
D3 8 9 sd1
I3 9 8 10.361114098081137

*elementary diode model
Rs4 9 10 0.005117383333333334
Rp4 10 11 5.118051725103711
D4 10 11 sd1
I4 11 10 10.361114098081137

*elementary diode model
Rs5 11 12 0.005117383333333334
Rp5 12 13 5.118051725103711
D5 12 13 sd1
I5 13 12 10.361114098081137

*elementary diode model
Rs6 13 14 0.005117383333333334
Rp6 14 15 5.118051725103711
D6 14 15 sd1
I6 15 14 10.361114098081137

*elementary diode model
Rs7 15 16 0.005117383333333334
Rp7 16 17 5.118051725103711
D7 16 17 sd1
I7 17 16 10.361114098081137

*elementary diode model
Rs8 17 18 0.005117383333333334
Rp8 18 19 5.118051725103711
D8 18 19 sd1
I8 19 18 10.361114098081137

*elementary diode model
Rs9 19 20 0.005117383333333334
Rp9 20 21 5.118051725103711
D9 20 21 sd1
I9 21 20 10.361114098081137

*elementary diode model
Rs10 21 22 0.005117383333333334
Rp10 22 23 5.118051725103711
D10 22 23 sd1
I10 23 22 10.361114098081137

*elementary diode model
Rs11 23 24 0.005117383333333334
Rp11 24 25 5.118051725103711
D11 24 25 sd1
I11 25 24 10.361114098081137

*elementary diode model
Rs12 25 26 0.005117383333333334
Rp12 26 27 5.118051725103711
D12 26 27 sd1
I12 27 26 10.361114098081137

*elementary diode model
Rs13 27 28 0.005117383333333334
Rp13 28 29 5.118051725103711
D13 28 29 sd1
I13 29 28 10.361114098081137

*elementary diode model
Rs14 29 30 0.005117383333333334
Rp14 30 31 5.118051725103711
D14 30 31 sd1
I14 31 30 10.361114098081137

*elementary diode model
Rs15 31 32 0.005117383333333334
Rp15 32 33 5.118051725103711
D15 32 33 sd1
I15 33 32 10.361114098081137

*elementary diode model
Rs16 33 34 0.005117383333333334
Rp16 34 35 5.118051725103711
D16 34 35 sd1
I16 35 34 10.361114098081137

*elementary diode model
Rs17 35 36 0.005117383333333334
Rp17 36 37 5.118051725103711
D17 36 37 sd1
I17 37 36 10.361114098081137

*elementary diode model
Rs18 37 38 0.005117383333333334
Rp18 38 39 5.118051725103711
D18 38 39 sd1
I18 39 38 10.361114098081137

*elementary diode model cell 19 byp
Rs19 39 40 0.005117383333333334
Rp19 40 41 5.118051725103711
D19 40 41 sd1
I19 41 40 10.361114098081137
*bypass diode
Dby19 41 1 sdby
*Rt19 1 41 0

*elementary diode model
Rs20 41 42 0.005117383333333334
Rp20 42 43 5.118051725103711
D20 42 43 sd1
I20 43 42 10.361114098081137

*elementary diode model
Rs21 43 44 0.005117383333333334
Rp21 44 45 5.118051725103711
D21 44 45 sd1
I21 45 44 10.361114098081137

*elementary diode model
Rs22 45 46 0.005117383333333334
Rp22 46 47 5.118051725103711
D22 46 47 sd1
I22 47 46 10.361114098081137

*elementary diode model
Rs23 47 48 0.005117383333333334
Rp23 48 49 5.118051725103711
D23 48 49 sd1
I23 49 48 10.361114098081137

*elementary diode model
Rs24 49 50 0.005117383333333334
Rp24 50 51 5.118051725103711
D24 50 51 sd1
I24 51 50 10.361114098081137

*elementary diode model
Rs25 51 52 0.005117383333333334
Rp25 52 53 5.118051725103711
D25 52 53 sd1
I25 53 52 10.361114098081137

*elementary diode model
Rs26 53 54 0.005117383333333334
Rp26 54 55 5.118051725103711
D26 54 55 sd1
I26 55 54 10.361114098081137

*elementary diode model
Rs27 55 56 0.005117383333333334
Rp27 56 57 5.118051725103711
D27 56 57 sd1
I27 57 56 10.361114098081137

*elementary diode model
Rs28 57 58 0.005117383333333334
Rp28 58 59 5.118051725103711
D28 58 59 sd1
I28 59 58 10.361114098081137

*elementary diode model
Rs29 59 60 0.005117383333333334
Rp29 60 61 5.118051725103711
D29 60 61 sd1
I29 61 60 10.361114098081137

*elementary diode model
Rs30 61 62 0.005117383333333334
Rp30 62 63 5.118051725103711
D30 62 63 sd1
I30 63 62 10.361114098081137

*elementary diode model
Rs31 63 64 0.005117383333333334
Rp31 64 65 5.118051725103711
D31 64 65 sd1
I31 65 64 10.361114098081137

*elementary diode model
Rs32 65 66 0.005117383333333334
Rp32 66 67 5.118051725103711
D32 66 67 sd1
I32 67 66 10.361114098081137

*elementary diode model
Rs33 67 68 0.005117383333333334
Rp33 68 69 5.118051725103711
D33 68 69 sd1
I33 69 68 10.361114098081137

*elementary diode model
Rs34 69 70 0.005117383333333334
Rp34 70 71 5.118051725103711
D34 70 71 sd1
I34 71 70 10.361114098081137

*elementary diode model
Rs35 71 72 0.005117383333333334
Rp35 72 73 5.118051725103711
D35 72 73 sd1
I35 73 72 10.361114098081137

*elementary diode model
Rs36 73 74 0.005117383333333334
Rp36 74 75 5.118051725103711
D36 74 75 sd1
I36 75 74 10.361114098081137

*elementary diode model
Rs37 75 76 0.005117383333333334
Rp37 76 77 5.118051725103711
D37 76 77 sd1
I37 77 76 10.361114098081137

*elementary diode model
Rs38 77 78 0.005117383333333334
Rp38 78 79 5.118051725103711
D38 78 79 sd1
I38 79 78 10.361114098081137

*elementary diode model cell 39 byp
Rs39 79 80 0.005117383333333334
Rp39 80 81 5.118051725103711
D39 80 81 sd1
I39 81 80 10.361114098081137
*bypass diode
Dby39 81 41 sdby

*elementary diode model
Rs40 81 82 0.005117383333333334
Rp40 82 83 5.118051725103711
D40 82 83 sd1
I40 83 82 10.361114098081137

*elementary diode model
Rs41 83 84 0.005117383333333334
Rp41 84 85 5.118051725103711
D41 84 85 sd1
I41 85 84 10.361114098081137

*elementary diode model
Rs42 85 86 0.005117383333333334
Rp42 86 87 5.118051725103711
D42 86 87 sd1
I42 87 86 10.361114098081137

*elementary diode model
Rs43 87 88 0.005117383333333334
Rp43 88 89 5.118051725103711
D43 88 89 sd1
I43 89 88 10.361114098081137

*elementary diode model
Rs44 89 90 0.005117383333333334
Rp44 90 91 5.118051725103711
D44 90 91 sd1
I44 91 90 10.361114098081137

*elementary diode model
Rs45 91 92 0.005117383333333334
Rp45 92 93 5.118051725103711
D45 92 93 sd1
I45 93 92 10.361114098081137

*elementary diode model
Rs46 93 94 0.005117383333333334
Rp46 94 95 5.118051725103711
D46 94 95 sd1
I46 95 94 10.361114098081137

*elementary diode model
Rs47 95 96 0.005117383333333334
Rp47 96 97 5.118051725103711
D47 96 97 sd1
I47 97 96 10.361114098081137

*elementary diode model
Rs48 97 98 0.005117383333333334
Rp48 98 99 5.118051725103711
D48 98 99 sd1
I48 99 98 10.361114098081137

*elementary diode model
Rs49 99 100 0.005117383333333334
Rp49 100 101 5.118051725103711
D49 100 101 sd1
I49 101 100 10.361114098081137

*elementary diode model
Rs50 101 102 0.005117383333333334
Rp50 102 103 10.03539553941904
D50 102 103 sd1
I50 103 102 5.324170169763301

*elementary diode model
Rs51 103 104 0.005117383333333334
Rp51 104 105 5.118051725103711
D51 104 105 sd1
I51 105 104 10.361114098081137

*elementary diode model
Rs52 105 106 0.005117383333333334
Rp52 106 107 5.118051725103711
D52 106 107 sd1
I52 107 106 10.361114098081137

*elementary diode model
Rs53 107 108 0.005117383333333334
Rp53 108 109 5.118051725103711
D53 108 109 sd1
I53 109 108 10.361114098081137

*elementary diode model
Rs54 109 110 0.005117383333333334
Rp54 110 111 5.118051725103711
D54 110 111 sd1
I54 111 110 10.361114098081137

*elementary diode model
Rs55 111 112 0.005117383333333334
Rp55 112 113 5.118051725103711
D55 112 113 sd1
I55 113 112 10.361114098081137

*elementary diode model
Rs56 113 114 0.005117383333333334
Rp56 114 115 5.118051725103711
D56 114 115 sd1
I56 115 114 10.361114098081137

*elementary diode model
Rs57 115 116 0.005117383333333334
Rp57 116 117 5.118051725103711
D57 116 117 sd1
I57 117 116 10.361114098081137

*elementary diode model
Rs58 117 118 0.005117383333333334
Rp58 118 119 5.118051725103711
D58 118 119 sd1
I58 119 118 10.361114098081137

*elementary diode model cell 59 byp
Rs59 119 120 0.005117383333333334
Rp59 120 0 5.118051725103711
D59 120 0 sd1
I59 0 120 10.361114098081137
*bypass diode
Dby59 0 81 sdby

.temp = 46.58517
.options tnom=46.58517
.control
dc V1 0 39.410981855577575 0.1
print dc v(1) i(D1)
set filetype=ascii
write c:\Users\Norman\pvcracks\docs\data\IVshaded\_thermal_fit_spice\row_013/solar_circuit.out
write c:\Users\Norman\pvcracks\docs\data\IVshaded\_thermal_fit_spice\row_013/solar_circuit.txt

quit
.endc
